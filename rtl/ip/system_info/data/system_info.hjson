// Copyright lowRISC contributors.
// Licensed under the Apache License, Version 2.0, see LICENSE for details.
// SPDX-License-Identifier: Apache-2.0

{
  name:               "system_info",
  human_name:         "System Information",
  one_line_desc:      "This module contains information about the system, for example the git hash.",
  one_paragraph_desc: "",
  cip_id:             "1",

  revisions: [
    {
      version:            "1.0.0",
      life_stage:         "L2",
      design_stage:       "D1",
      verification_stage: "V1",
      notes:              "",
    },
  ],

  clocking: [
    {clock: "clk_i", reset: "rst_ni", primary: true},
  ],
  bus_interfaces: [
    { protocol: "tlul", direction: "device" },
  ],
  available_input_list: [],
  available_output_list: [],
  interrupt_list: [],
  regwidth: "32",
  registers: [
    { name: "RTL_COMMIT_HASH_0",
      desc: '''This contains the git hash of the Sonata System repository when this bitstream was generated.
               This is useful to determine the configuration of the RTL.''',
      swaccess: "ro",
      hwaccess: "hwo",
      hwext: "true",
      fields: [
        { bits: "31:0",
          name: "HASH",
          desc: '''First 32-bits of the git SHA hash.''',
        },
      ],
    },
    { name: "RTL_COMMIT_HASH_1",
      desc: '''Extension of the RTL_COMMIT_HASH_0 register.''',
      swaccess: "ro",
      hwaccess: "hwo",
      hwext: "true",
      fields: [
        { bits: "31:0",
          name: "HASH",
          desc: '''Second 32-bits of the git SHA hash.''',
        },
      ],
    },
    { name: "RTL_COMMIT_DIRTY",
      desc: '''This contains whether the repository was dirty when the bitstream was generated.''',
      swaccess: "ro",
      hwaccess: "hwo",
      hwext: "true",
      fields: [
        { bits: "0",
          name: "DIRTY",
          desc: '''One if the git repository was dirty when generating the bitstream.
                   Zero if the git repository was clean.
                   This should be used in combination with the RTL_COMMIT_HASH register.''',
          resval: 1,
        },
      ],
    },
    { name: "SYSTEM_FREQUENCY",
      desc: '''Contains the system frequency.''',
      swaccess: "ro",
      hwaccess: "hwo",
      hwext: "true",
      fields: [
        { bits: "31:0",
          name: "FREQUENCY",
          desc: '''The frequency of the system clock in Hz.''',
        },
      ],
    },
    { name: "GPIO_INFO",
      desc: '''Contains information about the GPIO blocks in Sonata.''',
      swaccess: "ro",
      hwaccess: "hwo",
      hwext: "true",
      fields: [
        { bits: "7:0",
          name: "INSTANCES",
          desc: '''Number of GPIO block instances.''',
        },
      ],
    },
    { name: "UART_INFO",
      desc: '''Contains information about the UART blocks in Sonata.''',
      swaccess: "ro",
      hwaccess: "hwo",
      hwext: "true",
      fields: [
        { bits: "7:0",
          name: "INSTANCES",
          desc: '''Number of UART block instances.''',
        },
      ],
    },
    { name: "I2C_INFO",
      desc: '''Contains information about the I2C blocks in Sonata.''',
      swaccess: "ro",
      hwaccess: "hwo",
      hwext: "true",
      fields: [
        { bits: "7:0",
          name: "INSTANCES",
          desc: '''Number of I2C block instances.''',
        },
      ],
    },
    { name: "SPI_INFO",
      desc: '''Contains information about the SPI blocks in Sonata.''',
      swaccess: "ro",
      hwaccess: "hwo",
      hwext: "true",
      fields: [
        { bits: "7:0",
          name: "INSTANCES",
          desc: '''Number of SPI block instances.''',
        },
      ],
    },
  ],
}
