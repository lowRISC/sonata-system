// Copyright lowRISC contributors.
// Licensed under the Apache License, Version 2.0, see LICENSE for details.
// SPDX-License-Identifier: Apache-2.0

{
  name:               "system_info",
  human_name:         "System Information",
  one_line_desc:      "This module contains information about the system, for example the git hash.",
  one_paragraph_desc: "",
  cip_id:             "1",

  revisions: [
    {
      version:            "1.0.0",
      life_stage:         "L2",
      design_stage:       "D1",
      verification_stage: "V1",
      notes:              "",
    },
  ],

  clocking: [
    {clock: "clk_i", reset: "rst_ni", primary: true},
  ],
  bus_interfaces: [
    { protocol: "tlul", direction: "device" },
  ],
  available_input_list: [],
  available_output_list: [],
  interrupt_list: [],
  regwidth: "32",
  registers: [
    { name: "RTL_COMMIT_HASH_0",
      desc: '''This contains the git hash of the Sonata System repository when this bitstream was generated.
               This is useful to determine the configuration of the RTL.''',
      swaccess: "ro",
      hwaccess: "hwo",
      hwext: "true",
      fields: [
        { bits: "31:0",
          name: "HASH",
          desc: '''First 32-bits of the git SHA hash.''',
        },
      ],
    },
    { name: "RTL_COMMIT_HASH_1",
      desc: '''Extension of the RTL_COMMIT_HASH_0 register.''',
      swaccess: "ro",
      hwaccess: "hwo",
      hwext: "true",
      fields: [
        { bits: "31:0",
          name: "HASH",
          desc: '''Second 32-bits of the git SHA hash.''',
        },
      ],
    },
    { name: "RTL_COMMIT_DIRTY",
      desc: '''This contains whether the repository was dirty when the bitstream was generated.''',
      swaccess: "ro",
      hwaccess: "hwo",
      hwext: "true",
      fields: [
        { bits: "0",
          name: "DIRTY",
          desc: '''One if the git repository was dirty when generating the bitstream.
                   Zero if the git repository was clean.
                   This should be used in combination with the RTL_COMMIT_HASH register.''',
          resval: 1,
        },
      ],
    },
    { name: "SYSTEM_FREQUENCY",
      desc: '''Contains the system frequency.''',
      swaccess: "ro",
      hwaccess: "hwo",
      hwext: "true",
      fields: [
        { bits: "31:0",
          name: "FREQUENCY",
          desc: '''The frequency of the system clock in Hz.''',
        },
      ],
    },
    { name: "GPIO_INFO",
      desc: '''Contains information about the GPIO blocks in Sonata.''',
      swaccess: "ro",
      hwaccess: "hwo",
      hwext: "true",
      fields: [
        { bits: "7:0",
          name: "INSTANCES",
          desc: '''Number of GPIO block instances.''',
        },
      ],
    },
    { name: "UART_INFO",
      desc: '''Contains information about the UART blocks in Sonata.''',
      swaccess: "ro",
      hwaccess: "hwo",
      hwext: "true",
      fields: [
        { bits: "7:0",
          name: "INSTANCES",
          desc: '''Number of UART block instances.''',
        },
      ],
    },
    { name: "I2C_INFO",
      desc: '''Contains information about the I2C blocks in Sonata.''',
      swaccess: "ro",
      hwaccess: "hwo",
      hwext: "true",
      fields: [
        { bits: "7:0",
          name: "INSTANCES",
          desc: '''Number of I2C block instances.''',
        },
      ],
    },
    { name: "SPI_INFO",
      desc: '''Contains information about the SPI blocks in Sonata.''',
      swaccess: "ro",
      hwaccess: "hwo",
      hwext: "true",
      fields: [
        { bits: "7:0",
          name: "INSTANCES",
          desc: '''Number of SPI block instances.''',
        },
      ],
    },
    { name: "DNA_CAPTURE",
      desc: '''Capture the `DNA value` of this Sonata device for reading via the `DNA` register.
               A write to this register will present the first bit of the DNA value in `DNA.`
               The value written does not matter.''',
      swaccess: "wo",
      hwaccess: "hro",
      hwqe: "true",
      hwext: "true",
      fields: [
        { bits: "0",
          name: "CAPTURE"
          desc: '''Initiate reading of `DNA value`.''',
        },
      ]
    }
    { name: "DNA",
      desc: '''The next bit of the DNA value.
               Reading of the DNA value should be initiated by writing to `DNA_CAPTURE.`
               A single bit of the 57-bit DNA value is presented per read of the `DNA` register.
               Up to 32 FPGA devices within a family may have the same DNA value.''',
      swaccess: "ro",
      hwaccess: "hrw",
      hwre: "true",
      hwext: "true",
      fields: [
        { bits: "0",
          name: "DNA"
          desc: '''Next bit of DNA value.''',
        },
      ]
    }
    { name: "MEM_SIZE",
      desc: '''Size of main memory (SRAM) in KiB.''',
      swaccess: "ro",
      hwaccess: "hwo",
      hwext: "true",
      fields: [
        { bits: "31:0",
          name: "SIZE",
          desc: '''Size of main memory in KiB.''',
        },
      ]
    }
    { name: "HYPERRAM_SIZE",
      desc: '''Size of HyperRAM in KiB.''',
      swaccess: "ro",
      hwaccess: "hwo",
      hwext: "true",
      fields: [
        { bits: "31:0",
          name: "SIZE",
          desc: '''Size of HyperRAM in KiB.''',
        },
      ]
    }
    { name: "HYPERRAM_TAG_SIZE",
      desc: '''Size of tagged portion of HyperRAM in KiB.
               It may be the case that only the first portion of the HyperRAM supports tags.
               Storing a capability within the remainder of the HyperRAM will raise an error.''',
      swaccess: "ro",
      hwaccess: "hwo",
      hwext: "true",
      fields: [
        { bits: "31:0",
          name: "SIZE",
          desc: '''Size of tagged portion of HyperRAM in KiB.''',
        },
      ]
    }
  ],
}
