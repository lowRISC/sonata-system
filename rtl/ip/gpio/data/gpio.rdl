addrmap gpio {
  reg {
    field {
      sw=w;
      reset = 0;
      desc = "Pins.";
    } PINS[32] = 0;
  } OUT @0x0000;

  reg {
    field {
      sw=r;
      reset = 0;
      desc = "Pins.";
    } PINS[32] = 0;
  } IN @0x0004;

  reg {
    field {
      sw=r;
      reset = 0;
      desc = "DBNC.";
    } PINS[32] = 0;
  } IN_DBNC @0x0008;

  reg  {
    field {
      sw=rw;
      reset = 0;
      desc = "val";
    } PINS[32] = 0;
  } OUTPUT_ENABLE @0x000c;

};
