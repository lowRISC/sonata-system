addrmap pinmux {
  xbar = '{
    parameter'{ type_: "bool", name: "pipeline", value:  "true" },
    parameter'{ type_: "bool", name: "req_fifo_pass", value:  "false" },
    parameter'{ type_: "bool", name: "rsp_fifo_pass", value:  "false" }
  };
  clk_input = '{ "clk_sys_i" };
  rst_input = '{ "rst_sys_ni" };

  reg mux_t  {
    regwidth = 8;
    field {
      sw = rw;
      hw = rw;
    } val[7:0];
  };

  mux_t SER0_TX @ 0x000;
  mux_t SER1_TX @ 0x001;
  mux_t RS232_TX @ 0x002;
  mux_t RS485_TX @ 0x003;
  mux_t SCL0 @ 0x004;
  mux_t SDA0 @ 0x005;
  mux_t SCL1 @ 0x006;
  mux_t SDA1 @ 0x007;
  mux_t RPH_G0 @ 0x008;
  mux_t RPH_G1 @ 0x009;
  mux_t RPH_G2_SDA @ 0x00a;
  mux_t RPH_G3_SCL @ 0x00b;
  mux_t RPH_G4 @ 0x00c;
  mux_t RPH_G5 @ 0x00d;
  mux_t RPH_G6 @ 0x00e;
  mux_t RPH_G7 @ 0x00f;
  mux_t RPH_G8 @ 0x010;
  mux_t RPH_G9 @ 0x011;
  mux_t RPH_G10 @ 0x012;
  mux_t RPH_G11 @ 0x013;
  mux_t RPH_G12 @ 0x014;
  mux_t RPH_G13 @ 0x015;
  mux_t RPH_TXD0 @ 0x016;
  mux_t RPH_RXD0 @ 0x017;
  mux_t RPH_G16 @ 0x018;
  mux_t RPH_G17 @ 0x019;
  mux_t RPH_G18 @ 0x01a;
  mux_t RPH_G19 @ 0x01b;
  mux_t RPH_G20 @ 0x01c;
  mux_t RPH_G21 @ 0x01d;
  mux_t RPH_G22 @ 0x01e;
  mux_t RPH_G23 @ 0x01f;
  mux_t RPH_G24 @ 0x020;
  mux_t RPH_G25 @ 0x021;
  mux_t RPH_G26 @ 0x022;
  mux_t RPH_G27 @ 0x023;
  mux_t AH_TMPIO0 @ 0x024;
  mux_t AH_TMPIO1 @ 0x025;
  mux_t AH_TMPIO2 @ 0x026;
  mux_t AH_TMPIO3 @ 0x027;
  mux_t AH_TMPIO4 @ 0x028;
  mux_t AH_TMPIO5 @ 0x029;
  mux_t AH_TMPIO6 @ 0x02a;
  mux_t AH_TMPIO7 @ 0x02b;
  mux_t AH_TMPIO8 @ 0x02c;
  mux_t AH_TMPIO9 @ 0x02d;
  mux_t AH_TMPIO10 @ 0x02e;
  mux_t AH_TMPIO11 @ 0x02f;
  mux_t AH_TMPIO12 @ 0x030;
  mux_t AH_TMPIO13 @ 0x031;
  mux_t MB1 @ 0x032;
  mux_t MB2 @ 0x033;
  mux_t MB4 @ 0x034;
  mux_t MB5 @ 0x035;
  mux_t MB6 @ 0x036;
  mux_t MB7 @ 0x037;
  mux_t MB10 @ 0x038;
  mux_t PMOD0_1 @ 0x039;
  mux_t PMOD0_2 @ 0x03a;
  mux_t PMOD0_3 @ 0x03b;
  mux_t PMOD0_4 @ 0x03c;
  mux_t PMOD0_7 @ 0x03d;
  mux_t PMOD0_8 @ 0x03e;
  mux_t PMOD0_9 @ 0x03f;
  mux_t PMOD0_10 @ 0x040;
  mux_t PMOD1_1 @ 0x041;
  mux_t PMOD1_2 @ 0x042;
  mux_t PMOD1_3 @ 0x043;
  mux_t PMOD1_4 @ 0x044;
  mux_t PMOD1_7 @ 0x045;
  mux_t PMOD1_8 @ 0x046;
  mux_t PMOD1_9 @ 0x047;
  mux_t PMOD1_10 @ 0x048;
  mux_t PMODC_1 @ 0x049;
  mux_t PMODC_2 @ 0x04a;
  mux_t PMODC_3 @ 0x04b;
  mux_t PMODC_4 @ 0x04c;
  mux_t PMODC_5 @ 0x04d;
  mux_t PMODC_6 @ 0x04e;
  mux_t APPSPI_D0 @ 0x04f;
  mux_t APPSPI_CLK @ 0x050;
  mux_t APPSPI_CS @ 0x051;
  mux_t MICROSD_CMD @ 0x052;
  mux_t MICROSD_CLK @ 0x053;
  mux_t MICROSD_DAT3 @ 0x054;
};
